* NGSPICE file created from xor_it.ext - technology: sky130A

* Black-box entry subcircuit for sky130_fd_sc_hd__decap_8 abstract view
.subckt sky130_fd_sc_hd__decap_8 VGND VNB VPB VPWR
.ends

* Black-box entry subcircuit for sky130_fd_sc_hd__fill_1 abstract view
.subckt sky130_fd_sc_hd__fill_1 VGND VNB VPB VPWR
.ends

* Black-box entry subcircuit for sky130_fd_sc_hd__fill_2 abstract view
.subckt sky130_fd_sc_hd__fill_2 VGND VNB VPB VPWR
.ends

* Black-box entry subcircuit for sky130_fd_sc_hd__inv_2 abstract view
.subckt sky130_fd_sc_hd__inv_2 A VGND VNB VPB VPWR Y
.ends

* Black-box entry subcircuit for sky130_fd_sc_hd__buf_2 abstract view
.subckt sky130_fd_sc_hd__buf_2 A VGND VNB VPB VPWR X
.ends

* Black-box entry subcircuit for sky130_fd_sc_hd__clkbuf_4 abstract view
.subckt sky130_fd_sc_hd__clkbuf_4 A VGND VNB VPB VPWR X
.ends

* Black-box entry subcircuit for sky130_fd_sc_hd__decap_4 abstract view
.subckt sky130_fd_sc_hd__decap_4 VGND VNB VPB VPWR
.ends

* Black-box entry subcircuit for sky130_fd_sc_hd__a22o_1 abstract view
.subckt sky130_fd_sc_hd__a22o_1 A1 A2 B1 B2 VGND VNB VPB VPWR X
.ends

* Black-box entry subcircuit for sky130_ef_sc_hd__decap_12 abstract view
.subckt sky130_ef_sc_hd__decap_12 VPWR VGND VPB VNB
.ends

* Black-box entry subcircuit for sky130_fd_sc_hd__xor2_1 abstract view
.subckt sky130_fd_sc_hd__xor2_1 A B VGND VNB VPB VPWR X
.ends

* Black-box entry subcircuit for sky130_fd_sc_hd__and2_1 abstract view
.subckt sky130_fd_sc_hd__and2_1 A B VGND VNB VPB VPWR X
.ends

* Black-box entry subcircuit for sky130_fd_sc_hd__decap_3 abstract view
.subckt sky130_fd_sc_hd__decap_3 VGND VNB VPB VPWR
.ends

* Black-box entry subcircuit for sky130_fd_sc_hd__dfrtp_1 abstract view
.subckt sky130_fd_sc_hd__dfrtp_1 CLK D RESET_B VGND VNB VPB VPWR Q
.ends

* Black-box entry subcircuit for sky130_fd_sc_hd__o22a_1 abstract view
.subckt sky130_fd_sc_hd__o22a_1 A1 A2 B1 B2 VGND VNB VPB VPWR X
.ends

* Black-box entry subcircuit for sky130_fd_sc_hd__clkbuf_16 abstract view
.subckt sky130_fd_sc_hd__clkbuf_16 A VGND VNB VPB VPWR X
.ends

* Black-box entry subcircuit for sky130_fd_sc_hd__buf_1 abstract view
.subckt sky130_fd_sc_hd__buf_1 A VGND VNB VPB VPWR X
.ends

* Black-box entry subcircuit for sky130_fd_sc_hd__clkbuf_1 abstract view
.subckt sky130_fd_sc_hd__clkbuf_1 A VGND VNB VPB VPWR X
.ends

* Black-box entry subcircuit for sky130_fd_sc_hd__tapvpwrvgnd_1 abstract view
.subckt sky130_fd_sc_hd__tapvpwrvgnd_1 VGND VPWR
.ends

* Black-box entry subcircuit for sky130_fd_sc_hd__clkbuf_2 abstract view
.subckt sky130_fd_sc_hd__clkbuf_2 A VGND VNB VPB VPWR X
.ends

* Black-box entry subcircuit for sky130_fd_sc_hd__nand2_1 abstract view
.subckt sky130_fd_sc_hd__nand2_1 A B VGND VNB VPB VPWR Y
.ends

* Black-box entry subcircuit for sky130_fd_sc_hd__decap_6 abstract view
.subckt sky130_fd_sc_hd__decap_6 VGND VNB VPB VPWR
.ends

.subckt xor_it VGND VPWR change_defxor clk custom_xor[0] custom_xor[1] custom_xor[2]
+ custom_xor[3] custom_xor[4] custom_xor[5] custom_xor[6] custom_xor[7] data_in[0]
+ data_in[1] data_in[2] data_in[3] data_in[4] data_in[5] data_in[6] data_in[7] def_sig
+ new_def_xor[0] new_def_xor[1] new_def_xor[2] new_def_xor[3] new_def_xor[4] new_def_xor[5]
+ new_def_xor[6] new_def_xor[7] rst xored[0] xored[1] xored[2] xored[3] xored[4] xored[5]
+ xored[6] xored[7]
XFILLER_0_7_70 VGND VGND VPWR VPWR sky130_fd_sc_hd__decap_8
XFILLER_0_9_27 VGND VGND VPWR VPWR sky130_fd_sc_hd__fill_1
XFILLER_0_0_29 VGND VGND VPWR VPWR sky130_fd_sc_hd__fill_2
X_49_ net27 VGND VGND VPWR VPWR _11_ sky130_fd_sc_hd__inv_2
Xoutput31 net31 VGND VGND VPWR VPWR xored[3] sky130_fd_sc_hd__buf_2
XFILLER_0_9_39 VGND VGND VPWR VPWR sky130_fd_sc_hd__fill_1
X_48_ net27 VGND VGND VPWR VPWR _10_ sky130_fd_sc_hd__inv_2
XFILLER_0_6_29 VGND VGND VPWR VPWR sky130_fd_sc_hd__fill_2
Xoutput32 net32 VGND VGND VPWR VPWR xored[4] sky130_fd_sc_hd__clkbuf_4
X_47_ net27 VGND VGND VPWR VPWR _09_ sky130_fd_sc_hd__inv_2
XFILLER_0_9_3 VGND VGND VPWR VPWR sky130_fd_sc_hd__decap_4
Xoutput33 net33 VGND VGND VPWR VPWR xored[5] sky130_fd_sc_hd__clkbuf_4
XFILLER_0_4_41 VGND VGND VPWR VPWR sky130_fd_sc_hd__decap_8
XFILLER_0_9_19 VGND VGND VPWR VPWR sky130_fd_sc_hd__decap_8
X_46_ net27 VGND VGND VPWR VPWR _08_ sky130_fd_sc_hd__inv_2
Xoutput34 net34 VGND VGND VPWR VPWR xored[6] sky130_fd_sc_hd__clkbuf_4
X_29_ net5 _16_ _17_ net22 VGND VGND VPWR VPWR _18_ sky130_fd_sc_hd__a22o_1
XFILLER_0_7_41 VPWR VGND VPWR VGND sky130_ef_sc_hd__decap_12
X_45_ net12 _26_ VGND VGND VPWR VPWR _02_ sky130_fd_sc_hd__xor2_1
X_28_ net1 net18 VGND VGND VPWR VPWR _17_ sky130_fd_sc_hd__and2_1
XFILLER_0_7_53 VGND VGND VPWR VPWR sky130_fd_sc_hd__decap_3
Xoutput35 net35 VGND VGND VPWR VPWR xored[7] sky130_fd_sc_hd__clkbuf_4
XFILLER_0_0_9 VGND VGND VPWR VPWR sky130_fd_sc_hd__fill_1
X_61_ clknet_1_1__leaf_clk _07_ _15_ VGND VGND VPWR VPWR net35 sky130_fd_sc_hd__dfrtp_1
X_44_ net18 net4 _19_ net21 VGND VGND VPWR VPWR _26_ sky130_fd_sc_hd__o22a_1
X_27_ net18 VGND VGND VPWR VPWR _16_ sky130_fd_sc_hd__inv_2
XFILLER_0_7_65 VGND VGND VPWR VPWR sky130_fd_sc_hd__fill_2
XFILLER_0_7_3 VGND VGND VPWR VPWR sky130_fd_sc_hd__decap_4
XFILLER_0_7_10 VGND VGND VPWR VPWR sky130_fd_sc_hd__decap_8
XPHY_0 VGND VGND VPWR VPWR sky130_fd_sc_hd__decap_3
X_60_ clknet_1_0__leaf_clk _06_ _14_ VGND VGND VPWR VPWR net34 sky130_fd_sc_hd__dfrtp_1
X_43_ net11 _25_ VGND VGND VPWR VPWR _01_ sky130_fd_sc_hd__xor2_1
XPHY_1 VGND VGND VPWR VPWR sky130_fd_sc_hd__decap_3
X_42_ _16_ net3 _17_ net20 VGND VGND VPWR VPWR _25_ sky130_fd_sc_hd__a22o_1
XPHY_2 VGND VGND VPWR VPWR sky130_fd_sc_hd__decap_3
Xclkbuf_0_clk clk VGND VGND VPWR VPWR clknet_0_clk sky130_fd_sc_hd__clkbuf_16
XFILLER_0_4_79 VGND VGND VPWR VPWR sky130_fd_sc_hd__fill_2
X_41_ net10 _24_ VGND VGND VPWR VPWR _00_ sky130_fd_sc_hd__xor2_1
XFILLER_0_1_14 VGND VGND VPWR VPWR sky130_fd_sc_hd__fill_2
XFILLER_0_1_36 VPWR VGND VPWR VGND sky130_ef_sc_hd__decap_12
Xoutput28 net28 VGND VGND VPWR VPWR xored[0] sky130_fd_sc_hd__clkbuf_4
XFILLER_0_7_57 VGND VGND VPWR VPWR sky130_fd_sc_hd__decap_8
XPHY_3 VGND VGND VPWR VPWR sky130_fd_sc_hd__decap_3
X_40_ net18 net2 _19_ net19 VGND VGND VPWR VPWR _24_ sky130_fd_sc_hd__o22a_1
XFILLER_0_5_3 VPWR VGND VPWR VGND sky130_ef_sc_hd__decap_12
XFILLER_0_1_48 VGND VGND VPWR VPWR sky130_fd_sc_hd__fill_1
Xoutput29 net29 VGND VGND VPWR VPWR xored[1] sky130_fd_sc_hd__clkbuf_4
XPHY_4 VGND VGND VPWR VPWR sky130_fd_sc_hd__decap_3
XFILLER_0_2_80 VGND VGND VPWR VPWR sky130_fd_sc_hd__fill_1
XFILLER_0_4_26 VGND VGND VPWR VPWR sky130_fd_sc_hd__fill_2
XPHY_5 VGND VGND VPWR VPWR sky130_fd_sc_hd__decap_3
XFILLER_0_4_49 VGND VGND VPWR VPWR sky130_fd_sc_hd__decap_3
XPHY_6 VGND VGND VPWR VPWR sky130_fd_sc_hd__decap_3
XFILLER_0_3_3 VGND VGND VPWR VPWR sky130_fd_sc_hd__decap_8
Xinput1 change_defxor VGND VGND VPWR VPWR net1 sky130_fd_sc_hd__buf_1
XPHY_7 VGND VGND VPWR VPWR sky130_fd_sc_hd__decap_3
XFILLER_0_4_29 VPWR VGND VPWR VGND sky130_ef_sc_hd__decap_12
Xinput2 custom_xor[0] VGND VGND VPWR VPWR net2 sky130_fd_sc_hd__clkbuf_1
XPHY_8 VGND VGND VPWR VPWR sky130_fd_sc_hd__decap_3
Xinput3 custom_xor[1] VGND VGND VPWR VPWR net3 sky130_fd_sc_hd__clkbuf_1
XPHY_9 VGND VGND VPWR VPWR sky130_fd_sc_hd__decap_3
Xinput4 custom_xor[2] VGND VGND VPWR VPWR net4 sky130_fd_sc_hd__clkbuf_1
Xinput5 custom_xor[3] VGND VGND VPWR VPWR net5 sky130_fd_sc_hd__clkbuf_1
XFILLER_0_2_10 VGND VGND VPWR VPWR sky130_fd_sc_hd__fill_1
XFILLER_0_2_76 VGND VGND VPWR VPWR sky130_fd_sc_hd__decap_4
X_59_ clknet_1_0__leaf_clk _05_ _13_ VGND VGND VPWR VPWR net33 sky130_fd_sc_hd__dfrtp_1
Xinput6 custom_xor[4] VGND VGND VPWR VPWR net6 sky130_fd_sc_hd__clkbuf_1
X_58_ clknet_1_0__leaf_clk _04_ _12_ VGND VGND VPWR VPWR net32 sky130_fd_sc_hd__dfrtp_1
Xinput20 new_def_xor[1] VGND VGND VPWR VPWR net20 sky130_fd_sc_hd__clkbuf_1
XTAP_30 VGND VPWR sky130_fd_sc_hd__tapvpwrvgnd_1
Xinput7 custom_xor[5] VGND VGND VPWR VPWR net7 sky130_fd_sc_hd__clkbuf_1
XFILLER_0_1_6 VGND VGND VPWR VPWR sky130_fd_sc_hd__fill_1
XFILLER_0_5_77 VGND VGND VPWR VPWR sky130_fd_sc_hd__decap_4
Xinput21 new_def_xor[2] VGND VGND VPWR VPWR net21 sky130_fd_sc_hd__clkbuf_1
Xinput10 data_in[0] VGND VGND VPWR VPWR net10 sky130_fd_sc_hd__buf_1
XFILLER_0_2_34 VGND VGND VPWR VPWR sky130_fd_sc_hd__fill_2
X_57_ clknet_1_1__leaf_clk _03_ _11_ VGND VGND VPWR VPWR net31 sky130_fd_sc_hd__dfrtp_1
XTAP_31 VGND VPWR sky130_fd_sc_hd__tapvpwrvgnd_1
X_56_ clknet_1_1__leaf_clk _02_ _10_ VGND VGND VPWR VPWR net30 sky130_fd_sc_hd__dfrtp_1
Xinput8 custom_xor[6] VGND VGND VPWR VPWR net8 sky130_fd_sc_hd__clkbuf_1
XTAP_20 VGND VPWR sky130_fd_sc_hd__tapvpwrvgnd_1
Xinput11 data_in[1] VGND VGND VPWR VPWR net11 sky130_fd_sc_hd__buf_1
Xclkbuf_1_0__f_clk clknet_0_clk VGND VGND VPWR VPWR clknet_1_0__leaf_clk sky130_fd_sc_hd__clkbuf_16
Xinput22 new_def_xor[3] VGND VGND VPWR VPWR net22 sky130_fd_sc_hd__clkbuf_1
X_39_ net17 _23_ VGND VGND VPWR VPWR _07_ sky130_fd_sc_hd__xor2_1
Xinput9 custom_xor[7] VGND VGND VPWR VPWR net9 sky130_fd_sc_hd__clkbuf_1
XTAP_21 VGND VPWR sky130_fd_sc_hd__tapvpwrvgnd_1
X_55_ clknet_1_1__leaf_clk _01_ _09_ VGND VGND VPWR VPWR net29 sky130_fd_sc_hd__dfrtp_1
Xinput23 new_def_xor[4] VGND VGND VPWR VPWR net23 sky130_fd_sc_hd__clkbuf_1
Xinput12 data_in[2] VGND VGND VPWR VPWR net12 sky130_fd_sc_hd__buf_1
XFILLER_0_8_79 VGND VGND VPWR VPWR sky130_fd_sc_hd__fill_2
X_38_ _16_ net9 _17_ net26 VGND VGND VPWR VPWR _23_ sky130_fd_sc_hd__a22o_1
XFILLER_0_5_36 VPWR VGND VPWR VGND sky130_ef_sc_hd__decap_12
X_54_ clknet_1_0__leaf_clk _00_ _08_ VGND VGND VPWR VPWR net28 sky130_fd_sc_hd__dfrtp_1
XTAP_22 VGND VPWR sky130_fd_sc_hd__tapvpwrvgnd_1
Xinput24 new_def_xor[5] VGND VGND VPWR VPWR net24 sky130_fd_sc_hd__clkbuf_1
Xinput13 data_in[3] VGND VGND VPWR VPWR net13 sky130_fd_sc_hd__buf_1
X_37_ net16 _22_ VGND VGND VPWR VPWR _06_ sky130_fd_sc_hd__xor2_1
XFILLER_0_8_58 VGND VGND VPWR VPWR sky130_fd_sc_hd__fill_1
XTAP_23 VGND VPWR sky130_fd_sc_hd__tapvpwrvgnd_1
XFILLER_0_5_15 VGND VGND VPWR VPWR sky130_fd_sc_hd__fill_1
XFILLER_0_5_48 VGND VGND VPWR VPWR sky130_fd_sc_hd__decap_8
Xinput14 data_in[4] VGND VGND VPWR VPWR net14 sky130_fd_sc_hd__buf_1
Xinput25 new_def_xor[6] VGND VGND VPWR VPWR net25 sky130_fd_sc_hd__clkbuf_1
X_53_ net27 VGND VGND VPWR VPWR _15_ sky130_fd_sc_hd__inv_2
X_36_ net18 net8 _19_ net25 VGND VGND VPWR VPWR _22_ sky130_fd_sc_hd__o22a_1
X_52_ net27 VGND VGND VPWR VPWR _14_ sky130_fd_sc_hd__inv_2
XTAP_24 VGND VPWR sky130_fd_sc_hd__tapvpwrvgnd_1
Xinput15 data_in[5] VGND VGND VPWR VPWR net15 sky130_fd_sc_hd__clkbuf_1
X_35_ net15 _21_ VGND VGND VPWR VPWR _05_ sky130_fd_sc_hd__xor2_1
Xinput26 new_def_xor[7] VGND VGND VPWR VPWR net26 sky130_fd_sc_hd__clkbuf_1
XFILLER_0_8_49 VGND VGND VPWR VPWR sky130_fd_sc_hd__fill_2
XFILLER_0_8_27 VGND VGND VPWR VPWR sky130_fd_sc_hd__fill_1
XTAP_25 VGND VPWR sky130_fd_sc_hd__tapvpwrvgnd_1
X_51_ net27 VGND VGND VPWR VPWR _13_ sky130_fd_sc_hd__inv_2
Xinput27 rst VGND VGND VPWR VPWR net27 sky130_fd_sc_hd__clkbuf_4
Xinput16 data_in[6] VGND VGND VPWR VPWR net16 sky130_fd_sc_hd__buf_1
X_34_ _16_ net7 _17_ net24 VGND VGND VPWR VPWR _21_ sky130_fd_sc_hd__a22o_1
XPHY_10 VGND VGND VPWR VPWR sky130_fd_sc_hd__decap_3
XTAP_26 VGND VPWR sky130_fd_sc_hd__tapvpwrvgnd_1
Xinput17 data_in[7] VGND VGND VPWR VPWR net17 sky130_fd_sc_hd__clkbuf_1
X_33_ net14 _20_ VGND VGND VPWR VPWR _04_ sky130_fd_sc_hd__xor2_1
X_50_ net27 VGND VGND VPWR VPWR _12_ sky130_fd_sc_hd__inv_2
XFILLER_0_3_73 VGND VGND VPWR VPWR sky130_fd_sc_hd__fill_2
Xclkbuf_1_1__f_clk clknet_0_clk VGND VGND VPWR VPWR clknet_1_1__leaf_clk sky130_fd_sc_hd__clkbuf_16
XTAP_27 VGND VPWR sky130_fd_sc_hd__tapvpwrvgnd_1
XPHY_11 VGND VGND VPWR VPWR sky130_fd_sc_hd__decap_3
Xinput18 def_sig VGND VGND VPWR VPWR net18 sky130_fd_sc_hd__clkbuf_2
X_32_ net18 net6 _19_ net23 VGND VGND VPWR VPWR _20_ sky130_fd_sc_hd__o22a_1
XFILLER_0_3_41 VGND VGND VPWR VPWR sky130_fd_sc_hd__decap_8
XFILLER_0_9_62 VGND VGND VPWR VPWR sky130_fd_sc_hd__decap_4
XTAP_28 VGND VPWR sky130_fd_sc_hd__tapvpwrvgnd_1
XPHY_12 VGND VGND VPWR VPWR sky130_fd_sc_hd__decap_3
Xinput19 new_def_xor[0] VGND VGND VPWR VPWR net19 sky130_fd_sc_hd__clkbuf_1
X_31_ net1 net18 VGND VGND VPWR VPWR _19_ sky130_fd_sc_hd__nand2_1
XFILLER_0_0_65 VGND VGND VPWR VPWR sky130_fd_sc_hd__fill_2
XFILLER_0_0_76 VGND VGND VPWR VPWR sky130_fd_sc_hd__fill_2
XTAP_29 VGND VPWR sky130_fd_sc_hd__tapvpwrvgnd_1
XPHY_13 VGND VGND VPWR VPWR sky130_fd_sc_hd__decap_3
XFILLER_0_6_6 VGND VGND VPWR VPWR sky130_fd_sc_hd__decap_8
X_30_ net13 _18_ VGND VGND VPWR VPWR _03_ sky130_fd_sc_hd__xor2_1
XFILLER_0_3_54 VGND VGND VPWR VPWR sky130_fd_sc_hd__fill_2
XFILLER_0_6_65 VPWR VGND VPWR VGND sky130_ef_sc_hd__decap_12
XPHY_14 VGND VGND VPWR VPWR sky130_fd_sc_hd__decap_3
XPHY_15 VGND VGND VPWR VPWR sky130_fd_sc_hd__decap_3
XFILLER_0_6_77 VGND VGND VPWR VPWR sky130_fd_sc_hd__fill_1
XFILLER_0_9_55 VGND VGND VPWR VPWR sky130_fd_sc_hd__fill_1
XFILLER_0_9_44 VGND VGND VPWR VPWR sky130_fd_sc_hd__decap_8
XFILLER_0_0_57 VGND VGND VPWR VPWR sky130_fd_sc_hd__fill_2
XPHY_16 VGND VGND VPWR VPWR sky130_fd_sc_hd__decap_3
XFILLER_0_3_57 VGND VGND VPWR VPWR sky130_fd_sc_hd__decap_3
XPHY_17 VGND VGND VPWR VPWR sky130_fd_sc_hd__decap_3
XFILLER_0_0_37 VGND VGND VPWR VPWR sky130_fd_sc_hd__decap_8
XFILLER_0_0_48 VGND VGND VPWR VPWR sky130_fd_sc_hd__decap_8
XFILLER_0_9_57 VGND VGND VPWR VPWR sky130_fd_sc_hd__fill_2
XFILLER_0_9_35 VGND VGND VPWR VPWR sky130_fd_sc_hd__decap_4
XPHY_18 VGND VGND VPWR VPWR sky130_fd_sc_hd__decap_3
XFILLER_0_0_16 VGND VGND VPWR VPWR sky130_fd_sc_hd__decap_6
XPHY_19 VGND VGND VPWR VPWR sky130_fd_sc_hd__decap_3
XFILLER_0_6_37 VGND VGND VPWR VPWR sky130_fd_sc_hd__decap_8
XFILLER_0_4_9 VGND VGND VPWR VPWR sky130_fd_sc_hd__decap_3
XFILLER_0_2_6 VGND VGND VPWR VPWR sky130_fd_sc_hd__decap_4
XFILLER_0_3_49 VGND VGND VPWR VPWR sky130_fd_sc_hd__fill_2
XFILLER_0_1_71 VGND VGND VPWR VPWR sky130_fd_sc_hd__decap_4
Xoutput30 net30 VGND VGND VPWR VPWR xored[2] sky130_fd_sc_hd__clkbuf_4
.ends
